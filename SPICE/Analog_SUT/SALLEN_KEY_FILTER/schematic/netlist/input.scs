// Design: sallen_key_filter/sallen_key_filter
simulator lang=spectre
global 0
include "/softslin/AMS_410_ISR15/spectre/c35/soac/soac.scs"
parameters R5=4000 R4=4000 R3=2000 R2=1000 R1=5180.0 C2=5e-09 C1=5e-09
include "/softslin/AMS_410_ISR15/spectre/c35/soac/processOption.scs"
include "/softslin/AMS_410_ISR15/spectre/c35/soac/cmos53.scs" section=cmostm
include "/softslin/AMS_410_ISR15/spectre/c35/soac/res.scs" section=restm
include "/softslin/AMS_410_ISR15/spectre/c35/soac/cap.scs" section=captm
include "/softslin/AMS_410_ISR15/spectre/c35/soac/bip.scs" section=biptm
include "/softslin/AMS_410_ISR15/spectre/c35/soac/ind.scs" section=indtm
include "/softslin/AMS_410_ISR15/spectre/c35/soac/esddiode.scs" section=esddiodetm

// sallen_key_filter/sallen_key_filter/schematic
R5 (net1 0) resistor r=R3 c=0
R4 (net7 0) resistor r=R4 c=0
R3 (net7 V_out) resistor r=R5 c=0
R2 (net4 V_out) resistor r=R2 c=0
R1 (V_out 0) resistor r=10k c=0
R0 (V_in net4) resistor r=R1 c=0
C1 (net1 net4) capacitor c=C1
C0 (net4 0) capacitor c=C2
V0 (V_in 0) vsource type=pwl file="input_amprbs"
simulatorOptions options reltol=100e-6 temp=27 homotopy=all limit=delta compatible=spice2 enable_pre_ver=yes ignorezerovar=yes
tran tran stop=100m errpreset=conservative
