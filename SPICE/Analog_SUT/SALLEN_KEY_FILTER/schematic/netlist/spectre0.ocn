simulator( 'spectre )
design(	 "/tima/kouamoj/Documents/vituoso/sallen_key_filter/Sim/sallen_key_filter/spectre/schematic/netlist/netlist")
resultsDir( "/tima/kouamoj/Documents/vituoso/sallen_key_filter/Sim/sallen_key_filter/spectre/schematic" )
modelFile(
    '("/softslin/AMS_410_ISR15/spectre/c35/soac/processOption.scs" "")
    '("/softslin/AMS_410_ISR15/spectre/c35/soac/cmos53.scs" "cmostm")
    '("/softslin/AMS_410_ISR15/spectre/c35/soac/res.scs" "restm")
    '("/softslin/AMS_410_ISR15/spectre/c35/soac/cap.scs" "captm")
    '("/softslin/AMS_410_ISR15/spectre/c35/soac/bip.scs" "biptm")
    '("/softslin/AMS_410_ISR15/spectre/c35/soac/ind.scs" "indtm")
    '("/softslin/AMS_410_ISR15/spectre/c35/soac/esddiode.scs" "esddiodetm")
)
analysis('tran ?stop "2"  )
desVar(	  "R5" 4k	)
desVar(	  "R4" 4k	)
desVar(	  "R3" 2k	)
desVar(	  "R2" 1k	)
desVar(	  "R1" 5.18k	)
desVar(	  "M8" 10u	)
desVar(	  "M7" 10u	)
desVar(	  "M6" 10u	)
desVar(	  "M5" 10u	)
desVar(	  "M4" 10u	)
desVar(	  "M3" 10u	)
desVar(	  "M2" 10u	)
desVar(	  "M1" 10u	)
desVar(	  "C2" 5n	)
desVar(	  "C1" 5n	)
envOption(
	'enableNoiseRefactor  t
	'analysisOrder  list("tran")
)
save( 'v "/V_in" "/V_out" )
temp( 27 )
run()
selectResult( 'tran )
plot(getData("/V_in") getData("/V_out") )
