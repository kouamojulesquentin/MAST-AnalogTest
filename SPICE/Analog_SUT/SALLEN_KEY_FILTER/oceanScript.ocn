simulator( 'spectre )
design(	 "schematic/netlist/netlist")

analysis('tran ?stop "100m"  )
desVar(	  "C1" 5n	)
desVar(	  "C2" 5n	)
desVar(	  "R1" 5.18k	)
desVar(	  "R2" 1k	)
desVar(	  "R3" 2k	)
desVar(	  "R4" 4k	)
desVar(	  "R5" 4k	)

option( ?categ 'turboOpts
	'uniMode  "Spectre"
)

run()
selectResult( 'tran )
ocnPrint(getData("/V_out") ?output "data/V_out.txt" ?from 0 ?to 0.1 ?step 0.00006)
